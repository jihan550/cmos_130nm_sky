* SPICE netlist generated by Yosys 0.60+1 (git sha1 685515865, g++ 13.3.0-6ubuntu2~24.04 -fPIC -O3)
.subckt param_counter clk rst_n count.0 en count.1 load_value.1 load count.2 load_value.2 count.3 load_value.3 load_value.0

X0 count.0 en _abc_255_new_n15 sky130_fd_sc_hd__nand2_1
X1 count.1 _abc_255_new_n15 _abc_255_new_n16 sky130_fd_sc_hd__xnor2_1
X2 load_value.1 load _abc_255_auto_rtlil.cc:3568:MuxGate_248 _abc_255_new_n16 sky130_fd_sc_hd__mux2_1
X3 count.0 en load _abc_255_new_n18 sky130_fd_sc_hd__a21oi_1
X4 count.1 count.2 count.0 en load _abc_255_new_n19 sky130_fd_sc_hd__a41oi_1
X5 count.1 count.0 en count.2 _abc_255_new_n20 sky130_fd_sc_hd__a31o_1
X6 load load_value.2 _abc_255_new_n19 _abc_255_new_n20 _abc_255_auto_rtlil.cc:3568:MuxGate_250 sky130_fd_sc_hd__a22o_1
X7 count.3 _abc_255_new_n19 _abc_255_new_n22 sky130_fd_sc_hd__nand2_1
X8 count.3 load _abc_255_new_n23 sky130_fd_sc_hd__nor2_1
X9 load load_value.3 _abc_255_new_n23 _abc_255_new_n24 sky130_fd_sc_hd__a21oi_1
X10 _abc_255_new_n19 _abc_255_new_n24 _abc_255_new_n22 _abc_255_auto_rtlil.cc:3568:MuxGate_252 sky130_fd_sc_hd__o21ai_0
X11 load load_value.0 _abc_255_new_n26 sky130_fd_sc_hd__nand2_1
X12 count.0 en _abc_255_new_n18 _abc_255_new_n27 sky130_fd_sc_hd__o21ai_0
X13 _abc_255_new_n26 _abc_255_new_n27 _abc_255_auto_rtlil.cc:3568:MuxGate_254 sky130_fd_sc_hd__nand2_1
X14 clk _abc_255_auto_rtlil.cc:3568:MuxGate_248 count.1 rst_n sky130_fd_sc_hd__dfrtp_1
X15 clk _abc_255_auto_rtlil.cc:3568:MuxGate_250 count.2 rst_n sky130_fd_sc_hd__dfrtp_1
X16 clk _abc_255_auto_rtlil.cc:3568:MuxGate_252 count.3 rst_n sky130_fd_sc_hd__dfrtp_1
X17 clk _abc_255_auto_rtlil.cc:3568:MuxGate_254 count.0 rst_n sky130_fd_sc_hd__dfrtp_1

.ends param_counter
************************
* end of SPICE netlist *
************************
