* SPICE netlist generated by Yosys 0.59+134 (git sha1 34fa8a4ff, g++ 13.3.0-6ubuntu2~24.04 -fPIC -O3)
.subckt counter_4bit clk reset count.0 count.1 count.2 count.3 VGND

X0 reset _abc_679_auto_rtlil.cc:3571:NotGate_672 sky130_fd_sc_hd__clkinv_1
X1 count.0 _techmap_add_/home/jihan/projects/units/top/rtl/counter_4bit.sv:7_2._auto_alumacc.cc:512:replace_alu_81.P.0 sky130_fd_sc_hd__clkinv_1
X2 count.0 count.1 _techmap_add_/home/jihan/projects/units/top/rtl/counter_4bit.sv:7_2._auto_alumacc.cc:512:replace_alu_81.Y.1 sky130_fd_sc_hd__xor2_1
X3 count.0 count.1 count.2 _abc_679_new_n17 sky130_fd_sc_hd__nand3_1
X4 count.0 count.1 count.2 _abc_679_new_n18 sky130_fd_sc_hd__a21oi_1
X5 _abc_679_new_n17 _techmap_add_/home/jihan/projects/units/top/rtl/counter_4bit.sv:7_2._auto_alumacc.cc:512:replace_alu_81.Y.2 _abc_679_new_n18 sky130_fd_sc_hd__lpflow_isobufsrc_1
X6 count.3 _abc_679_new_n17 _techmap_add_/home/jihan/projects/units/top/rtl/counter_4bit.sv:7_2._auto_alumacc.cc:512:replace_alu_81.Y.3 sky130_fd_sc_hd__xnor2_1
X7 reset _abc_679_auto_rtlil.cc:3571:NotGate_674 sky130_fd_sc_hd__clkinv_1
X8 reset _abc_679_auto_rtlil.cc:3571:NotGate_676 sky130_fd_sc_hd__clkinv_1
X9 reset _abc_679_auto_rtlil.cc:3571:NotGate_678 sky130_fd_sc_hd__clkinv_1
X10 clk _techmap_add_/home/jihan/projects/units/top/rtl/counter_4bit.sv:7_2._auto_alumacc.cc:512:replace_alu_81.P.0 count.0 _abc_679_auto_rtlil.cc:3571:NotGate_672 sky130_fd_sc_hd__dfrtp_1
X11 clk _techmap_add_/home/jihan/projects/units/top/rtl/counter_4bit.sv:7_2._auto_alumacc.cc:512:replace_alu_81.Y.1 count.1 _abc_679_auto_rtlil.cc:3571:NotGate_674 sky130_fd_sc_hd__dfrtp_1
X12 clk _techmap_add_/home/jihan/projects/units/top/rtl/counter_4bit.sv:7_2._auto_alumacc.cc:512:replace_alu_81.Y.2 count.2 _abc_679_auto_rtlil.cc:3571:NotGate_676 sky130_fd_sc_hd__dfrtp_1
X13 clk _techmap_add_/home/jihan/projects/units/top/rtl/counter_4bit.sv:7_2._auto_alumacc.cc:512:replace_alu_81.Y.3 count.3 _abc_679_auto_rtlil.cc:3571:NotGate_678 sky130_fd_sc_hd__dfrtp_1
V0 count.1 _techmap_add_/home/jihan/projects/units/top/rtl/counter_4bit.sv:7_2._auto_alumacc.cc:512:replace_alu_81.P.1 DC 0
V1 count.2 _techmap_add_/home/jihan/projects/units/top/rtl/counter_4bit.sv:7_2._auto_alumacc.cc:512:replace_alu_81.P.2 DC 0
V2 count.3 _techmap_add_/home/jihan/projects/units/top/rtl/counter_4bit.sv:7_2._auto_alumacc.cc:512:replace_alu_81.P.3 DC 0
V3 VGND _techmap_add_/home/jihan/projects/units/top/rtl/counter_4bit.sv:7_2._auto_alumacc.cc:512:replace_alu_81.P.4 DC 0
V4 VGND _techmap_add_/home/jihan/projects/units/top/rtl/counter_4bit.sv:7_2._auto_alumacc.cc:512:replace_alu_81.P.5 DC 0
V5 VGND _techmap_add_/home/jihan/projects/units/top/rtl/counter_4bit.sv:7_2._auto_alumacc.cc:512:replace_alu_81.P.6 DC 0
V6 VGND _techmap_add_/home/jihan/projects/units/top/rtl/counter_4bit.sv:7_2._auto_alumacc.cc:512:replace_alu_81.P.7 DC 0
V7 VGND _techmap_add_/home/jihan/projects/units/top/rtl/counter_4bit.sv:7_2._auto_alumacc.cc:512:replace_alu_81.P.8 DC 0
V8 VGND _techmap_add_/home/jihan/projects/units/top/rtl/counter_4bit.sv:7_2._auto_alumacc.cc:512:replace_alu_81.P.9 DC 0
V9 VGND _techmap_add_/home/jihan/projects/units/top/rtl/counter_4bit.sv:7_2._auto_alumacc.cc:512:replace_alu_81.P.10 DC 0
V10 VGND _techmap_add_/home/jihan/projects/units/top/rtl/counter_4bit.sv:7_2._auto_alumacc.cc:512:replace_alu_81.P.11 DC 0
V11 VGND _techmap_add_/home/jihan/projects/units/top/rtl/counter_4bit.sv:7_2._auto_alumacc.cc:512:replace_alu_81.P.12 DC 0
V12 VGND _techmap_add_/home/jihan/projects/units/top/rtl/counter_4bit.sv:7_2._auto_alumacc.cc:512:replace_alu_81.P.13 DC 0
V13 VGND _techmap_add_/home/jihan/projects/units/top/rtl/counter_4bit.sv:7_2._auto_alumacc.cc:512:replace_alu_81.P.14 DC 0
V14 VGND _techmap_add_/home/jihan/projects/units/top/rtl/counter_4bit.sv:7_2._auto_alumacc.cc:512:replace_alu_81.P.15 DC 0
V15 VGND _techmap_add_/home/jihan/projects/units/top/rtl/counter_4bit.sv:7_2._auto_alumacc.cc:512:replace_alu_81.P.16 DC 0
V16 VGND _techmap_add_/home/jihan/projects/units/top/rtl/counter_4bit.sv:7_2._auto_alumacc.cc:512:replace_alu_81.P.17 DC 0
V17 VGND _techmap_add_/home/jihan/projects/units/top/rtl/counter_4bit.sv:7_2._auto_alumacc.cc:512:replace_alu_81.P.18 DC 0
V18 VGND _techmap_add_/home/jihan/projects/units/top/rtl/counter_4bit.sv:7_2._auto_alumacc.cc:512:replace_alu_81.P.19 DC 0
V19 VGND _techmap_add_/home/jihan/projects/units/top/rtl/counter_4bit.sv:7_2._auto_alumacc.cc:512:replace_alu_81.P.20 DC 0
V20 VGND _techmap_add_/home/jihan/projects/units/top/rtl/counter_4bit.sv:7_2._auto_alumacc.cc:512:replace_alu_81.P.21 DC 0
V21 VGND _techmap_add_/home/jihan/projects/units/top/rtl/counter_4bit.sv:7_2._auto_alumacc.cc:512:replace_alu_81.P.22 DC 0
V22 VGND _techmap_add_/home/jihan/projects/units/top/rtl/counter_4bit.sv:7_2._auto_alumacc.cc:512:replace_alu_81.P.23 DC 0
V23 VGND _techmap_add_/home/jihan/projects/units/top/rtl/counter_4bit.sv:7_2._auto_alumacc.cc:512:replace_alu_81.P.24 DC 0
V24 VGND _techmap_add_/home/jihan/projects/units/top/rtl/counter_4bit.sv:7_2._auto_alumacc.cc:512:replace_alu_81.P.25 DC 0
V25 VGND _techmap_add_/home/jihan/projects/units/top/rtl/counter_4bit.sv:7_2._auto_alumacc.cc:512:replace_alu_81.P.26 DC 0
V26 VGND _techmap_add_/home/jihan/projects/units/top/rtl/counter_4bit.sv:7_2._auto_alumacc.cc:512:replace_alu_81.P.27 DC 0
V27 VGND _techmap_add_/home/jihan/projects/units/top/rtl/counter_4bit.sv:7_2._auto_alumacc.cc:512:replace_alu_81.P.28 DC 0
V28 VGND _techmap_add_/home/jihan/projects/units/top/rtl/counter_4bit.sv:7_2._auto_alumacc.cc:512:replace_alu_81.P.29 DC 0
V29 VGND _techmap_add_/home/jihan/projects/units/top/rtl/counter_4bit.sv:7_2._auto_alumacc.cc:512:replace_alu_81.P.30 DC 0
V30 VGND _techmap_add_/home/jihan/projects/units/top/rtl/counter_4bit.sv:7_2._auto_alumacc.cc:512:replace_alu_81.P.31 DC 0
V31 _techmap_add_/home/jihan/projects/units/top/rtl/counter_4bit.sv:7_2._auto_alumacc.cc:512:replace_alu_81.P.0 _techmap_add_/home/jihan/projects/units/top/rtl/counter_4bit.sv:7_2._auto_alumacc.cc:512:replace_alu_81.Y.0 DC 0
V32 VGND _techmap_add_/home/jihan/projects/units/top/rtl/counter_4bit.sv:7_2._auto_alumacc.cc:512:replace_alu_81.Y.5 DC 0
V33 VGND _techmap_add_/home/jihan/projects/units/top/rtl/counter_4bit.sv:7_2._auto_alumacc.cc:512:replace_alu_81.Y.6 DC 0
V34 VGND _techmap_add_/home/jihan/projects/units/top/rtl/counter_4bit.sv:7_2._auto_alumacc.cc:512:replace_alu_81.Y.7 DC 0
V35 VGND _techmap_add_/home/jihan/projects/units/top/rtl/counter_4bit.sv:7_2._auto_alumacc.cc:512:replace_alu_81.Y.8 DC 0
V36 VGND _techmap_add_/home/jihan/projects/units/top/rtl/counter_4bit.sv:7_2._auto_alumacc.cc:512:replace_alu_81.Y.9 DC 0
V37 VGND _techmap_add_/home/jihan/projects/units/top/rtl/counter_4bit.sv:7_2._auto_alumacc.cc:512:replace_alu_81.Y.10 DC 0
V38 VGND _techmap_add_/home/jihan/projects/units/top/rtl/counter_4bit.sv:7_2._auto_alumacc.cc:512:replace_alu_81.Y.11 DC 0
V39 VGND _techmap_add_/home/jihan/projects/units/top/rtl/counter_4bit.sv:7_2._auto_alumacc.cc:512:replace_alu_81.Y.12 DC 0
V40 VGND _techmap_add_/home/jihan/projects/units/top/rtl/counter_4bit.sv:7_2._auto_alumacc.cc:512:replace_alu_81.Y.13 DC 0
V41 VGND _techmap_add_/home/jihan/projects/units/top/rtl/counter_4bit.sv:7_2._auto_alumacc.cc:512:replace_alu_81.Y.14 DC 0
V42 VGND _techmap_add_/home/jihan/projects/units/top/rtl/counter_4bit.sv:7_2._auto_alumacc.cc:512:replace_alu_81.Y.15 DC 0
V43 VGND _techmap_add_/home/jihan/projects/units/top/rtl/counter_4bit.sv:7_2._auto_alumacc.cc:512:replace_alu_81.Y.16 DC 0
V44 VGND _techmap_add_/home/jihan/projects/units/top/rtl/counter_4bit.sv:7_2._auto_alumacc.cc:512:replace_alu_81.Y.17 DC 0
V45 VGND _techmap_add_/home/jihan/projects/units/top/rtl/counter_4bit.sv:7_2._auto_alumacc.cc:512:replace_alu_81.Y.18 DC 0
V46 VGND _techmap_add_/home/jihan/projects/units/top/rtl/counter_4bit.sv:7_2._auto_alumacc.cc:512:replace_alu_81.Y.19 DC 0
V47 VGND _techmap_add_/home/jihan/projects/units/top/rtl/counter_4bit.sv:7_2._auto_alumacc.cc:512:replace_alu_81.Y.20 DC 0
V48 VGND _techmap_add_/home/jihan/projects/units/top/rtl/counter_4bit.sv:7_2._auto_alumacc.cc:512:replace_alu_81.Y.21 DC 0
V49 VGND _techmap_add_/home/jihan/projects/units/top/rtl/counter_4bit.sv:7_2._auto_alumacc.cc:512:replace_alu_81.Y.22 DC 0
V50 VGND _techmap_add_/home/jihan/projects/units/top/rtl/counter_4bit.sv:7_2._auto_alumacc.cc:512:replace_alu_81.Y.23 DC 0
V51 VGND _techmap_add_/home/jihan/projects/units/top/rtl/counter_4bit.sv:7_2._auto_alumacc.cc:512:replace_alu_81.Y.24 DC 0
V52 VGND _techmap_add_/home/jihan/projects/units/top/rtl/counter_4bit.sv:7_2._auto_alumacc.cc:512:replace_alu_81.Y.25 DC 0
V53 VGND _techmap_add_/home/jihan/projects/units/top/rtl/counter_4bit.sv:7_2._auto_alumacc.cc:512:replace_alu_81.Y.26 DC 0
V54 VGND _techmap_add_/home/jihan/projects/units/top/rtl/counter_4bit.sv:7_2._auto_alumacc.cc:512:replace_alu_81.Y.27 DC 0
V55 VGND _techmap_add_/home/jihan/projects/units/top/rtl/counter_4bit.sv:7_2._auto_alumacc.cc:512:replace_alu_81.Y.28 DC 0
V56 VGND _techmap_add_/home/jihan/projects/units/top/rtl/counter_4bit.sv:7_2._auto_alumacc.cc:512:replace_alu_81.Y.29 DC 0
V57 VGND _techmap_add_/home/jihan/projects/units/top/rtl/counter_4bit.sv:7_2._auto_alumacc.cc:512:replace_alu_81.Y.30 DC 0
V58 VGND _techmap_add_/home/jihan/projects/units/top/rtl/counter_4bit.sv:7_2._auto_alumacc.cc:512:replace_alu_81.Y.31 DC 0

.ends counter_4bit
************************
* end of SPICE netlist *
************************
